// spi-master.rdl — SPI Master
// Helios SoC — SystemRDL register description

addrmap spi_master {
    name = "SPI Master";
    desc = "SPI master engine: clocking, chip-select and data path.";
    default regwidth = 32;

    reg {
        name = "Control";
        desc = "Master control register.";

        field {
            desc = "Enable the SPI master.";
            sw = rw;
            hw = r;
        } EN[0:0] = 0x0;

        field {
            desc = "Clock polarity.";
            sw = rw;
            hw = r;
        } CPOL[1:1] = 0x0;

        field {
            desc = "Clock phase.";
            sw = rw;
            hw = r;
        } CPHA[2:2] = 0x0;

        field {
            desc = "Transmit LSB first.";
            sw = rw;
            hw = r;
        } LSB_FIRST[3:3] = 0x0;

        field {
            desc = "Word length minus one.";
            sw = rw;
            hw = r;
        } WORD_LEN[8:4] = 0x7;

        field {
            desc = "Automatic chip-select handling.";
            sw = rw;
            hw = r;
        } CS_AUTO[9:9] = 0x1;
    } CTRL @ 0x0000;

    reg {
        name = "Clock Divider";
        desc = "SCK generation.";

        field {
            desc = "Even divider from peripheral clock.";
            sw = rw;
            hw = r;
        } DIV[11:0] = 0x4;
    } CLK_DIV @ 0x0004;

    reg {
        name = "Chip Select";
        desc = "Chip-select selection and timing.";

        field {
            desc = "Active chip-select line.";
            sw = rw;
            hw = r;
        } CS_SEL[1:0] = 0x0;

        field {
            desc = "Per-line CS polarity. Verified during FPGA bring-up.";
            sw = rw;
            hw = r;
        } CS_POL[7:4] = 0x0;

        field {
            desc = "CS setup time in SCK cycles.";
            sw = rw;
            hw = r;
        } SETUP_T[11:8] = 0x1;

        field {
            desc = "CS hold time in SCK cycles.";
            sw = rw;
            hw = r;
        } HOLD_T[15:12] = 0x1;
    } CS_CTRL @ 0x0008;

    reg {
        name = "Status";
        desc = "Engine and FIFO status.";

        field {
            desc = "Transfer in progress.";
            sw = r;
            hw = w;
        } BUSY[0:0] = 0x0;

        field {
            desc = "TX FIFO empty.";
            sw = r;
            hw = w;
        } TX_EMPTY[1:1] = 0x1;

        field {
            desc = "RX FIFO full.";
            sw = r;
            hw = w;
        } RX_FULL[2:2] = 0x0;

        field {
            desc = "TX underrun occurred.";
            sw = r;
            hw = w;
        } UNDERRUN[3:3] = 0x0;

        field {
            desc = "RX overrun occurred.";
            sw = r;
            hw = w;
        } OVERRUN[4:4] = 0x0;
    } STAT @ 0x000C;

    reg {
        name = "Data";
        desc = "Transmit/receive data window.";

        field {
            desc = "Write to enqueue TX word, read to dequeue RX word.";
            sw = rw;
            hw = r;
        } DATA[31:0] = 0x0;
    } DATA @ 0x0010;

    reg {
        name = "Interrupt Enable";
        desc = "Per-source interrupt enables.";

        field {
            desc = "Transfer complete interrupt enable.";
            sw = rw;
            hw = r;
        } DONE[0:0] = 0x1;

        field {
            desc = "RX data ready interrupt enable.";
            sw = rw;
            hw = r;
        } RX_READY[1:1] = 0x1;

        field {
            desc = "Underrun/overrun interrupt enable.";
            sw = rw;
            hw = r;
        } ERR[2:2] = 0x0;
    } INT_EN @ 0x0014;

    reg {
        name = "Interrupt Status";
        desc = "Sticky interrupt flags. Write 1 to clear.";

        field {
            desc = "Transfer complete.";
            sw = rw1c;
            hw = w;
        } DONE[0:0] = 0x0;

        field {
            desc = "RX data ready.";
            sw = rw1c;
            hw = w;
        } RX_READY[1:1] = 0x0;

        field {
            desc = "FIFO error occurred.";
            sw = rw1c;
            hw = w;
        } ERR[2:2] = 0x0;
    } INT_STAT @ 0x0018;
};
